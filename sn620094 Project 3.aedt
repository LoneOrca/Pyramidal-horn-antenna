# Ansys Electronics Desktop project, version 2023.2
materials:
  vacuum: permittivity=1
  pec: conductivity=1e+30

design Horn Antenna Full Model (HFSS, HFSS Modal Network, model units mm)
variables:
  a = 15.7988mm
  b = 7.8994mm
  t = 2.54mm
  aw = a+2*t
  bw = b+2*t
  Aap = 166.8913mm
  Bap = 133.6658mm
  Rp = 392.2487mm
  Aapw = Aap+2*t
  Bapw = Bap+2*t
  L = 0.5*a
geometry:
  Horn [vacuum] = rectangle(corner=(-Aap/2, -Bap/2, 0mm), x_size=Aap, y_size=Bap)
  Rectangle2 = rectangle(corner=(-(1/2)*a, -(1/2)*b, -Rp), x_size=a, y_size=b)
  Horn_Walls [pec] = rectangle(corner=(-(1/2)*Aapw, -(1/2)*Bapw, 0mm), x_size=Aapw, y_size=Bapw)
  Rectangle3 = rectangle(corner=(-(1/2)*aw, -(1/2)*bw, -Rp), x_size=aw, y_size=bw)
  Horn.connect(Rectangle2)
  Horn_Walls.connect(Rectangle3)
  WG [vacuum] = box(corner=(-(1/2)*a, -(1/2)*b, -Rp), size=(a, b, -L))
  WG_walls [pec] = box(corner=(-(1/2)*aw, -(1/2)*bw, -Rp), size=(aw, bw, -(L+t)))
  RadiatingSurface [vacuum] = region(absolute_offset=9.0909091mm on all sides)
boundaries and excitations:
  Open1: Radiation Objects=RadiatingSurface
  1: Wave Port Faces=WG.face(-z) WavePortType=Default NumModes=1 DeembedDist=L Modes{Mode1{IntLine{(0, -3.9497, -400.1481) -> (300mm, 3700mm, -400148.1mm)} CharImp=Zpv}}
setups:
  Setup1: HfssDriven Frequency=14GHz MaxDeltaS=0.001 MaximumPasses=15 MinimumPasses=1 MinimumConvergedPasses=1 PercentRefinement=30 BasisOrder=2 PortAccuracy=2 DrivenSolverType="Iterative Solver" IterativeResidual=1e-06 DDMSolverResidual=0.0001
    sweep Sweep: 12.5GHz to 15.5GHz step 10MHz; Type=Interpolating InterpTolerance=0.5 InterpMaxSolns=250 InterpUsePortImped=false PassivityErrorTolerance=0.0001
source amplitudes:
  1:1: 1W 0deg
radiation setups:
  3D: Infinite Sphere Theta=0deg..180deg step 2deg Phi=-180deg..180deg step 2deg
  Elevation: Infinite Sphere Theta=-180deg..180deg step 1deg Phi=0deg..90deg step 90deg
  Azimuth: Infinite Sphere Theta=90deg..90deg step 0deg Phi=-180deg..180deg step 1deg

design Horn Antenna Half Model (HFSS, HFSS Modal Network, model units mm)
variables:
  a = 15.7988mm
  b = 7.8994mm
  t = 2.54mm
  aw = a+2*t
  bw = b+2*t
  Aap = 166.8913mm
  Bap = 133.6658mm
  Rp = 392.2487mm
  Aapw = Aap+2*t
  Bapw = Bap+2*t
  L = 0.5*a
geometry:
  Horn [vacuum] = rectangle(corner=(-Aap/2, -Bap/2, 0mm), x_size=Aap, y_size=Bap)
  Rectangle2 = rectangle(corner=(-(1/2)*a, -(1/2)*b, -Rp), x_size=a, y_size=b)
  Horn_Walls [pec] = rectangle(corner=(-(1/2)*Aapw, -(1/2)*Bapw, 0mm), x_size=Aapw, y_size=Bapw)
  Rectangle3 = rectangle(corner=(-(1/2)*aw, -(1/2)*bw, -Rp), x_size=aw, y_size=bw)
  Horn.connect(Rectangle2)
  Horn_Walls.connect(Rectangle3)
  WG [vacuum] = box(corner=(-(1/2)*a, -(1/2)*b, -Rp), size=(a, b, -L))
  WG_walls [pec] = box(corner=(-(1/2)*aw, -(1/2)*bw, -Rp), size=(aw, bw, -(L+t)))
  RadiatingSurface [vacuum] = region(absolute_offset: +X=9.0909091mm, -X=0mm, +Y=9.0909091mm, -Y=0mm, +Z=9.0909091mm, -Z=9.0909091mm)
  [Horn, Horn_Walls, WG, WG_walls].split(plane=YZ, keep=PositiveOnly)
  [Horn, Horn_Walls, WG, WG_walls].split(plane=ZX, keep=PositiveOnly)
boundaries and excitations:
  Open1: Radiation Objects=RadiatingSurface
  Sym1: Symmetry Faces=RadiatingSurface.face(-y) IsPerfectE=true
  Sym2: Symmetry Faces=RadiatingSurface.face(-x) IsPerfectE=false
  1: Wave Port Faces=WG.face(-z) WavePortType=Modal NumModes=1 DeembedDist=L Modes{Mode1{IntLine{(3.9497, 0, -400.1481) -> (3900mm, 3700mm, -400148.1mm)} CharImp=Zpv}}
setups:
  Setup1: HfssDriven Frequency=14GHz MaxDeltaS=0.001 MaximumPasses=15 MinimumPasses=1 MinimumConvergedPasses=1 PercentRefinement=30 BasisOrder=2 PortAccuracy=2 DrivenSolverType="Iterative Solver" IterativeResidual=1e-06 DDMSolverResidual=0.0001
    sweep Sweep: 12.5GHz to 15.5GHz step 10MHz; Type=Interpolating InterpTolerance=0.5 InterpMaxSolns=250 InterpUsePortImped=false PassivityErrorTolerance=0.0001
source amplitudes:
  1:1: 1W 0deg
radiation setups:
  3D: Infinite Sphere Theta=0deg..180deg step 2deg Phi=-180deg..180deg step 2deg
  Elevation: Infinite Sphere Theta=-180deg..180deg step 1deg Phi=0deg..90deg step 90deg
  Azimuth: Infinite Sphere Theta=90deg..90deg step 0deg Phi=-180deg..180deg step 1deg
reports:
  S Parameter Plot 1: dB(S(1,1)) vs Freq on Setup1 : Sweep
  S Parameter Plot 2: dB(S(1,1)) vs Freq on Setup1 : Sweep
  Gain Plot 1: dB(GainTotal) vs Theta on Setup1 : LastAdaptive, Elevation [Phi=all Freq=14GHz]
  Gain Plot 2: dB(GainTotal) vs Theta on Setup1 : LastAdaptive, Elevation [Phi=all Freq=14GHz]
